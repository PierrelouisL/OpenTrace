.title KiCad schematic
H1 __H1
H3 __H3
H2 __H2
H4 __H4
IC14 __IC14
IC12 __IC12
R39 /DebugConnector/SPI_NSS_0 /DebugConnector/VTRef 10k
IC2 __IC2
IC7 __IC7
IC6 __IC6
IC3 __IC3
C62 VDD1V8 GND 100n
R61 Net-_IC12-_INT_ VDD1V8 100k
C63 /DebugConnector/VTRef GND 100n
R5 Net-_IC12-_RESET_ VDD1V8 100k
C60 /DebugConnector/VTRef GND 100n
IC11 __IC11
IC10 __IC10
J3 __J3
C57 Net-_J3-Pin_1_ GND 100n
U6 __U6
IC8 __IC8
IC9 __IC9
C95 VDD1V GND 100n
C94 VDD1V GND 100n
C92 Net-_U1B-VCCAUX_ GND 100n
C93 Net-_U1B-VCCAUX_ GND 100n
L2 VDD1V8 Net-_U1B-VCCPLL_LLC_ BLM15AG121SN1D
C21 Net-_U1B-VCCPLL_LLC_ GND 10u
U1 __U1
C20 Net-_U1B-VCCPLL_LLC_ GND 2.2u
C55 VDD1V GND 100n
C87 VDD1V GND 100n
C91 Net-_U1B-VCCAUX_ GND 100n
C89 Net-_U1B-VCCAUX_ GND 100n
C13 Net-_U1B-VCCAUX_ GND 10u
C90 Net-_U1B-VCCAUX_ GND 100n
C14 Net-_U1B-VCCAUX_ GND 10u
C22 VDD1V GND 10u
C23 VDD1V GND 10u
C28 VDD1V GND 10u
C86 VDD1V GND 100n
L1 VDD1V8 Net-_U1B-VCCAUX_ BLM31KN121SN1L
C88 VDD1V GND 100n
JP1 __JP1
U8 __U8
C73 VDD3V3 GND 100n
R69 Net-_JP1-A_ VDD3V3 4.7k
C48 VDD1V8 GND 100n
R45 GND Net-_U1C-AON_OUT_ 10k
R2 Net-_U1C-AON_INT_ GND 10k
JP2 __JP2
Y2 __Y2
R50 Net-_JP2-B_ VDD1V8 10k
R1 VDD1V8 Net-_U1C-AON_INT_ 10k
C84 VDD1V8 GND 100n
L10 VDD1V8 Net-_Y2-VCC_ MPZ1005S121CT000
C76 Net-_Y2-VCC_ GND 1u
C46 VDD1V8 GND 100n
C47 VDD1V8 GND 10u
R42 Net-_U1C-REXT23_ GND 300
C40 Net-_U1C-AVDD18_ GND 10u
C37 Net-_U1C-AVDD18_ GND 100n
C39 Net-_U1C-AVDD18_ GND 100n
C38 Net-_U1C-AVDD18_ GND 100n
C50 VDD1V8 GND 10u
U9 __U9
R16 /FPGA/TCK GND 2.2k
R17 /FPGA/JTAG_EN VDD1V8 1k
R76 /FPGA/SSRX_F- /FPGA/SSRX- 0
R93 /FPGA/SSTX_F- /FPGA/SSTX- 0
R77 /FPGA/SSRX_F+ /FPGA/SSRX+ 0
R94 /FPGA/SSTX_F+ /FPGA/SSTX+ 0
R48 /DebugConnector/TraceD2 Net-_U1D-PB34B/PCLKC2_0_ 33
R56 /DebugConnector/TraceD1 Net-_U1D-PB32A/VREF2_1_ 33
R55 /DebugConnector/TraceD0 Net-_U1D-PB36A_ 33
R59 /DebugConnector/TraceD3 Net-_U1D-PB32B_ 33
R58 /DebugConnector/TraceCLK_RTCK Net-_U1D-PB34A/PCLKT2_0_ 33
C85 VDD1V8 GND 10u
C56 VDD1V8 GND 100n
C44 Net-_U1C-AVDD33_ GND 10u
L3 Net-_U1C-AVDD33_ VDD3V3 BLM41PG600SN1L
R78 /FPGA/FPGA_SDA /FPGA/USB_CTRL_SDA1v8 0
R79 /FPGA/FPGA_SCL /FPGA/USB_CTRL_SCL1v8 0
C45 Net-_U1C-AVDD33_ GND 100n
R86 /DebugConnector/SPI_CLK1 Net-_U1D-PB16A/PCLKT3_2_ 33
R95 /DebugConnector/SPI_CLK0 /FPGA/FLASH_SCK 33
R96 /DebugConnector/SPI_MISO0 /FPGA/FLASH_IO1 33
R97 /DebugConnector/SPI_MOSI0 /FPGA/FLASH_IO0 33
R99 /DebugConnector/SPI_CLK2 Net-_U1D-PB18A/PCLKT3_3/VREF3_2_ 33
R100 /DebugConnector/SPI_MOSI2 Net-_U1D-PB18B/PCLKC3_3_ 33
R98 /DebugConnector/SPI_MISO2 Net-_U1D-PB16B/PCLKC3_2_ 33
C42 Net-_U1C-AVDD_ GND 100n
C43 Net-_U1C-AVDD_ GND 10u
C41 Net-_U1C-AVDD_ GND 100n
L7 Net-_U1C-AVDD18_ VDD1V8 BLM41PG600SN1L
L5 Net-_U1C-AVDD_ VDD1V BLM41PG600SN1L
C49 Net-_U1C-VBUS_ GND 100n
R41 Net-_U1C-VBUS_ /FPGA/VBUS 4.7k
R57 /DebugConnector/SWO_TDO Net-_U1D-PB10B/PCLKC3_0_ 33
R52 /DebugConnector/SWDIO_TMS Net-_U1D-PB8A/VREF3_1_ 33
R49 /DebugConnector/SWCLK_TCK Net-_U1D-PB10A/PCLKT3_0_ 33
R51 /DebugConnector/_TDI Net-_U1D-PB8B_ 33
C59 VDD1V8 GND 10u
C58 VDD1V8 GND 100n
R70 /DebugConnector/SPI_MOSI1 Net-_U1D-PB14A/PCLKT3_1_ 33
R71 /DebugConnector/SPI_MISO1 Net-_U1D-PB14B/PCLKC3_1_ 33
R8 Net-_U1A-PT32A/MCLK_ /FPGA/FLASH_SCK 33
R4 Net-_U1A-PT34B/MISO/MD1_ /FPGA/FLASH_IO1 33
C97 VDD1V8 GND 100n
R10 /FPGA/FLASH_IO0 Net-_U1A-PT34A/MOSI/MD0_ 33
R9 /FPGA/FLASH_IO3 Net-_U1A-PT36B/MD3_ 33
R3 /FPGA/FLASH_IO2 Net-_U1A-PT36A/MD2_ 33
C52 VDD1V8 GND 10u
U10 __U10
U11 __U11
C96 VDD1V8 GND 100n
C54 VDD1V8 GND 10u
J2 __J2
R87 /DebugConnector/SDA /FPGA/FPGA_SDA 0
R88 /DebugConnector/SCL /FPGA/FPGA_SCL 0
J6 __J6
R90 /DebugConnector/MCU_BOOT_PIN Net-_J2-Pin_11_ 0
R89 /DebugConnector/UART_TX Net-_J2-Pin_11_ 0
U12 __U12
R6 Net-_R6-Pad1_ /microcontroller/USR_INPUT 10k
R14 VDD1V8 /DebugConnector/nRST 10k
R44 /DebugConnector/MCU_BOOT_PIN GND 50k
Y1 __Y1
C10 GND Net-_U13-PC15_ 5.1p
C6 Net-_U13-VCAP_ GND 4.7u
R43 VDD1V8 /DebugConnector/MCU_BOOT_PIN 50k
C5 VDD1V8 GND 100n
C7 VDD1V8 GND 4.7u
C4 VDD1V8 GND 100n
C8 VDD1V8 GND 4.7u
C9 GND Net-_U13-PC14_ 5.1p
Q10 __Q10
R64 Net-_D3-K_ Net-_Q10-D_ 330
R26 /microcontroller/TIM1_CH2 Net-_Q10-G_ 30k
Q9 __Q9
R28 /microcontroller/TIM1_CH3 Net-_Q9-G_ 30k
R25 /microcontroller/TIM1_CH1 Net-_Q8-G_ 30k
Q8 __Q8
D1 Net-_D1-K_ VDD3V3 LED
R47 Net-_D1-K_ Net-_Q8-D_ 330
D2 Net-_D2-K_ VDD3V3 LED
R62 Net-_D2-K_ Net-_Q9-D_ 330
D3 Net-_D3-K_ VDD3V3 LED
U13 __U13
R54 /FPGA/VBUS Net-_PS1-EN_ 18.2k
C68 /FPGA/VBUS GND 10u
R60 GND Net-_PS1-EN_ 12.7k
L6 Net-_PS2-SW_ /Power/test1v 1.5u
C71 /Power/test1v GND 22u
C72 /Power/test1v GND 22u
C70 Net-_PS2-BST_ Net-_PS2-SW_ 0.1u
R66 /Power/test1v Net-_PS2-FB_ 2.61k
R67 Net-_PS2-FB_ GND 10k
R68 /Power/test1v VDD1V 0
C66 /Power/test1v8 GND 22u
R21 /Power/test1v8 Net-_PS1-FB_ 12.4k
C74 /Power/test1v8 Net-_PS1-FB_ 50p
R29 Net-_PS1-FB_ GND 10k
L9 Net-_PS1-SW_ /Power/test1v8 3.3u
R46 /Power/test1v8 VDD1V8 0
J4 __J4
C67 /Power/test1v8 GND 22u
C65 Net-_PS1-BST_ Net-_PS1-SW_ 0.1u
PS1 __PS1
U3 __U3
C64 /Power/test3v3 GND 10u
C61 /FPGA/VBUS GND 10u
R53 /Power/test3v3 VDD3V3 0
C69 /FPGA/VBUS GND 10u
PS2 __PS2
R63 /FPGA/VBUS Net-_PS2-EN_ 18.2k
R65 GND Net-_PS2-EN_ 12.7k
IC5 __IC5
C1 GND /FPGA/VBUS 2.2u
C2 GND Net-_IC5-VBUS_POWER_ 1u
C3 GND Net-_IC13-VBUS_ 1u
IC1 __IC1
C77 VDD3V3 GND 100n
C75 VDD3V3 GND 100n
R27 VDD3V3 Net-_IC13-SCL_ 4.7k
R24 VDD3V3 Net-_IC13-SDA_ 4.7k
C79 /USB3/SSTX1- /USB3/SSTX1_- 220n
C78 /USB3/SSTX1+ /USB3/SSTX1_+ 220n
C80 /USB3/SSTX2- /USB3/SSTX2_+ 220n
C81 /USB3/SSTX2+ /USB3/SSTX2_- 220n
R74 /USB3/SSRX1+ /USB3/SSRX1_+ 0
R75 /USB3/SSRX1- /USB3/SSRX1_- 0
R72 /USB3/SSRX2+ /USB3/SSRX2_+ 0
R73 /USB3/SSRX2- /USB3/SSRX2_- 0
Q5 __Q5
Q7 __Q7
IC13 __IC13
U4 __U4
U5 __U5
L4 __L4
R40 VDD1V8 Net-_IC15-CS#_ 10k
R7 Net-_IC15-CS#_ GND 10k
C35 VDD1V8 GND 4.7u
C34 VDD1V8 GND 0.1u
C33 VDD1V8 GND 4.7u
IC15 __IC15
C32 VDD1V8 GND 0.1u
R11 /FPGA/FLASH_SCK VDD1V8 4.7k
R23 /FPGA/FLASH_CS# VDD1V8 4.7k
C31 VDD1V8 GND 100n
IC4 __IC4
.end
